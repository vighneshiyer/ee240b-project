ADE simulation setup
Run mode: Single Run, Sweeps and Corners
Tests:
  OTA:OTA_cmreject_tb:1: AAAFOO_OTA/OTA_cmreject_tb/schematic, simulator spectre
    Outputs: out_ac_amp; out_ac_phase; out_dc; out_ac_cmrr
Global variables:
  ibias = 6.25u
  supply = 1.2
  nf_input = 6
  nf_cas = 6
  nf_load = 12
  mos_l = 180n
  mos_w = 500n
  bcasp = 0.45
  bcasn = 1.1
  test_cmrr = 1
Corners (nominal off):
  model folders: /home/ff/ee240b/sp18/gpdk/gpdk045_v_5_0/models/spectre
  tt: temperature=25; gpdk045.scs[tt]
  ff: temperature=70; gpdk045.scs[ff]
  ss: temperature=0; gpdk045.scs[ss]
  sf: temperature=25; gpdk045.scs[sf]
  fs: temperature=25; gpdk045.scs[fs]
