ADE simulation setup
Run mode: Single Run, Sweeps and Corners
Tests:
  OTA:OTA_cmreject_tb:1: AAAFOO_OTA_single/OTA_single_tb/config, simulator spectre
    Outputs: out_ac_amp; out_ac_phase; out_dc
Global variables:
  ibias = 2.000000e-05
  in_bias = 7.000000e-01
  supply = 1.200000e+00
  nf_input = 4.000000e+00
  nf_load = 4.000000e+00
  Rfilt = 31.8K
  Cfilt = 400f
  cfilt = 400f
  rfilt = 31.8K
  mos_l = 180n
  mos_w = 1u
  nf_cas = 20
  bcasp = 0.5
  bcasn = 0.9
Corners (nominal off):
  model folders: /home/ff/ee240b/sp18/gpdk/gpdk045_v_5_0/models/spectre
  tt: temperature=25; gpdk045.scs[tt]
  ff (off): temperature=70; gpdk045.scs[ff]
  ss (off): temperature=0; gpdk045.scs[ss]
  sf (off): temperature=25; gpdk045.scs[sf]
  fs (off): temperature=25; gpdk045.scs[fs]
