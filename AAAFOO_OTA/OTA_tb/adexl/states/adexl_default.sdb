ADE simulation setup
Run mode: Single Run, Sweeps and Corners
Tests:
  OTA:OTA_tb:1: AAAFOO_OTA/OTA_tb/config, simulator spectre
Global variables:
  in_bias = 7.000000e-01
  supply = 1.200000e+00
  nf = 4.000000e+00
Corners (nominal off):
  model folders: /home/ff/ee240b/sp18/gpdk/gpdk045_v_5_0/models/spectre
  tt: temperature=25; gpdk045.scs[tt]
  ff (off): temperature=70; gpdk045.scs[ff]
  ss (off): temperature=0; gpdk045.scs[ss]
  sf (off): temperature=25; gpdk045.scs[sf]
  fs (off): temperature=25; gpdk045.scs[fs]
